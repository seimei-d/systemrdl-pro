// Auto-generated stress fixture: 1000 regs × 30 fields. Regenerate with examples/gen_stress.py.

reg stress_reg_t {
    name = "Stress test register";
    desc = "30 single-bit flags. Bits 30..31 reserved.";
    field { sw=rw; hw=r; desc="Flag 00."; } f00[0:0] = 0;
    field { sw=rw; hw=r; desc="Flag 01."; } f01[1:1] = 0;
    field { sw=rw; hw=r; desc="Flag 02."; } f02[2:2] = 0;
    field { sw=rw; hw=r; desc="Flag 03."; } f03[3:3] = 0;
    field { sw=rw; hw=r; desc="Flag 04."; } f04[4:4] = 0;
    field { sw=rw; hw=r; desc="Flag 05."; } f05[5:5] = 0;
    field { sw=rw; hw=r; desc="Flag 06."; } f06[6:6] = 0;
    field { sw=rw; hw=r; desc="Flag 07."; } f07[7:7] = 0;
    field { sw=rw; hw=r; desc="Flag 08."; } f08[8:8] = 0;
    field { sw=rw; hw=r; desc="Flag 09."; } f09[9:9] = 0;
    field { sw=rw; hw=r; desc="Flag 10."; } f10[10:10] = 0;
    field { sw=rw; hw=r; desc="Flag 11."; } f11[11:11] = 0;
    field { sw=rw; hw=r; desc="Flag 12."; } f12[12:12] = 0;
    field { sw=rw; hw=r; desc="Flag 13."; } f13[13:13] = 0;
    field { sw=rw; hw=r; desc="Flag 14."; } f14[14:14] = 0;
    field { sw=rw; hw=r; desc="Flag 15."; } f15[15:15] = 0;
    field { sw=rw; hw=r; desc="Flag 16."; } f16[16:16] = 0;
    field { sw=rw; hw=r; desc="Flag 17."; } f17[17:17] = 0;
    field { sw=rw; hw=r; desc="Flag 18."; } f18[18:18] = 0;
    field { sw=rw; hw=r; desc="Flag 19."; } f19[19:19] = 0;
    field { sw=rw; hw=r; desc="Flag 20."; } f20[20:20] = 0;
    field { sw=rw; hw=r; desc="Flag 21."; } f21[21:21] = 0;
    field { sw=rw; hw=r; desc="Flag 22."; } f22[22:22] = 0;
    field { sw=rw; hw=r; desc="Flag 23."; } f23[23:23] = 0;
    field { sw=rw; hw=r; desc="Flag 24."; } f24[24:24] = 0;
    field { sw=rw; hw=r; desc="Flag 25."; } f25[25:25] = 0;
    field { sw=rw; hw=r; desc="Flag 26."; } f26[26:26] = 0;
    field { sw=rw; hw=r; desc="Flag 27."; } f27[27:27] = 0;
    field { sw=rw; hw=r; desc="Flag 28."; } f28[28:28] = 0;
    field { sw=rw; hw=r; desc="Flag 29."; } f29[29:29] = 0;
};

regfile bank_00_t {
    name = "Bank 00";
    desc = "Bank 00: 100 registers.";
    stress_reg_t REG_000 @ 0x0000;
    stress_reg_t REG_001 @ 0x0004;
    stress_reg_t REG_002 @ 0x0008;
    stress_reg_t REG_003 @ 0x000C;
    stress_reg_t REG_004 @ 0x0010;
    stress_reg_t REG_005 @ 0x0014;
    stress_reg_t REG_006 @ 0x0018;
    stress_reg_t REG_007 @ 0x001C;
    stress_reg_t REG_008 @ 0x0020;
    stress_reg_t REG_009 @ 0x0024;
    stress_reg_t REG_010 @ 0x0028;
    stress_reg_t REG_011 @ 0x002C;
    stress_reg_t REG_012 @ 0x0030;
    stress_reg_t REG_013 @ 0x0034;
    stress_reg_t REG_014 @ 0x0038;
    stress_reg_t REG_015 @ 0x003C;
    stress_reg_t REG_016 @ 0x0040;
    stress_reg_t REG_017 @ 0x0044;
    stress_reg_t REG_018 @ 0x0048;
    stress_reg_t REG_019 @ 0x004C;
    stress_reg_t REG_020 @ 0x0050;
    stress_reg_t REG_021 @ 0x0054;
    stress_reg_t REG_022 @ 0x0058;
    stress_reg_t REG_023 @ 0x005C;
    stress_reg_t REG_024 @ 0x0060;
    stress_reg_t REG_025 @ 0x0064;
    stress_reg_t REG_026 @ 0x0068;
    stress_reg_t REG_027 @ 0x006C;
    stress_reg_t REG_028 @ 0x0070;
    stress_reg_t REG_029 @ 0x0074;
    stress_reg_t REG_030 @ 0x0078;
    stress_reg_t REG_031 @ 0x007C;
    stress_reg_t REG_032 @ 0x0080;
    stress_reg_t REG_033 @ 0x0084;
    stress_reg_t REG_034 @ 0x0088;
    stress_reg_t REG_035 @ 0x008C;
    stress_reg_t REG_036 @ 0x0090;
    stress_reg_t REG_037 @ 0x0094;
    stress_reg_t REG_038 @ 0x0098;
    stress_reg_t REG_039 @ 0x009C;
    stress_reg_t REG_040 @ 0x00A0;
    stress_reg_t REG_041 @ 0x00A4;
    stress_reg_t REG_042 @ 0x00A8;
    stress_reg_t REG_043 @ 0x00AC;
    stress_reg_t REG_044 @ 0x00B0;
    stress_reg_t REG_045 @ 0x00B4;
    stress_reg_t REG_046 @ 0x00B8;
    stress_reg_t REG_047 @ 0x00BC;
    stress_reg_t REG_048 @ 0x00C0;
    stress_reg_t REG_049 @ 0x00C4;
    stress_reg_t REG_050 @ 0x00C8;
    stress_reg_t REG_051 @ 0x00CC;
    stress_reg_t REG_052 @ 0x00D0;
    stress_reg_t REG_053 @ 0x00D4;
    stress_reg_t REG_054 @ 0x00D8;
    stress_reg_t REG_055 @ 0x00DC;
    stress_reg_t REG_056 @ 0x00E0;
    stress_reg_t REG_057 @ 0x00E4;
    stress_reg_t REG_058 @ 0x00E8;
    stress_reg_t REG_059 @ 0x00EC;
    stress_reg_t REG_060 @ 0x00F0;
    stress_reg_t REG_061 @ 0x00F4;
    stress_reg_t REG_062 @ 0x00F8;
    stress_reg_t REG_063 @ 0x00FC;
    stress_reg_t REG_064 @ 0x0100;
    stress_reg_t REG_065 @ 0x0104;
    stress_reg_t REG_066 @ 0x0108;
    stress_reg_t REG_067 @ 0x010C;
    stress_reg_t REG_068 @ 0x0110;
    stress_reg_t REG_069 @ 0x0114;
    stress_reg_t REG_070 @ 0x0118;
    stress_reg_t REG_071 @ 0x011C;
    stress_reg_t REG_072 @ 0x0120;
    stress_reg_t REG_073 @ 0x0124;
    stress_reg_t REG_074 @ 0x0128;
    stress_reg_t REG_075 @ 0x012C;
    stress_reg_t REG_076 @ 0x0130;
    stress_reg_t REG_077 @ 0x0134;
    stress_reg_t REG_078 @ 0x0138;
    stress_reg_t REG_079 @ 0x013C;
    stress_reg_t REG_080 @ 0x0140;
    stress_reg_t REG_081 @ 0x0144;
    stress_reg_t REG_082 @ 0x0148;
    stress_reg_t REG_083 @ 0x014C;
    stress_reg_t REG_084 @ 0x0150;
    stress_reg_t REG_085 @ 0x0154;
    stress_reg_t REG_086 @ 0x0158;
    stress_reg_t REG_087 @ 0x015C;
    stress_reg_t REG_088 @ 0x0160;
    stress_reg_t REG_089 @ 0x0164;
    stress_reg_t REG_090 @ 0x0168;
    stress_reg_t REG_091 @ 0x016C;
    stress_reg_t REG_092 @ 0x0170;
    stress_reg_t REG_093 @ 0x0174;
    stress_reg_t REG_094 @ 0x0178;
    stress_reg_t REG_095 @ 0x017C;
    stress_reg_t REG_096 @ 0x0180;
    stress_reg_t REG_097 @ 0x0184;
    stress_reg_t REG_098 @ 0x0188;
    stress_reg_t REG_099 @ 0x018C;
};

regfile bank_01_t {
    name = "Bank 01";
    desc = "Bank 01: 100 registers.";
    stress_reg_t REG_000 @ 0x0000;
    stress_reg_t REG_001 @ 0x0004;
    stress_reg_t REG_002 @ 0x0008;
    stress_reg_t REG_003 @ 0x000C;
    stress_reg_t REG_004 @ 0x0010;
    stress_reg_t REG_005 @ 0x0014;
    stress_reg_t REG_006 @ 0x0018;
    stress_reg_t REG_007 @ 0x001C;
    stress_reg_t REG_008 @ 0x0020;
    stress_reg_t REG_009 @ 0x0024;
    stress_reg_t REG_010 @ 0x0028;
    stress_reg_t REG_011 @ 0x002C;
    stress_reg_t REG_012 @ 0x0030;
    stress_reg_t REG_013 @ 0x0034;
    stress_reg_t REG_014 @ 0x0038;
    stress_reg_t REG_015 @ 0x003C;
    stress_reg_t REG_016 @ 0x0040;
    stress_reg_t REG_017 @ 0x0044;
    stress_reg_t REG_018 @ 0x0048;
    stress_reg_t REG_019 @ 0x004C;
    stress_reg_t REG_020 @ 0x0050;
    stress_reg_t REG_021 @ 0x0054;
    stress_reg_t REG_022 @ 0x0058;
    stress_reg_t REG_023 @ 0x005C;
    stress_reg_t REG_024 @ 0x0060;
    stress_reg_t REG_025 @ 0x0064;
    stress_reg_t REG_026 @ 0x0068;
    stress_reg_t REG_027 @ 0x006C;
    stress_reg_t REG_028 @ 0x0070;
    stress_reg_t REG_029 @ 0x0074;
    stress_reg_t REG_030 @ 0x0078;
    stress_reg_t REG_031 @ 0x007C;
    stress_reg_t REG_032 @ 0x0080;
    stress_reg_t REG_033 @ 0x0084;
    stress_reg_t REG_034 @ 0x0088;
    stress_reg_t REG_035 @ 0x008C;
    stress_reg_t REG_036 @ 0x0090;
    stress_reg_t REG_037 @ 0x0094;
    stress_reg_t REG_038 @ 0x0098;
    stress_reg_t REG_039 @ 0x009C;
    stress_reg_t REG_040 @ 0x00A0;
    stress_reg_t REG_041 @ 0x00A4;
    stress_reg_t REG_042 @ 0x00A8;
    stress_reg_t REG_043 @ 0x00AC;
    stress_reg_t REG_044 @ 0x00B0;
    stress_reg_t REG_045 @ 0x00B4;
    stress_reg_t REG_046 @ 0x00B8;
    stress_reg_t REG_047 @ 0x00BC;
    stress_reg_t REG_048 @ 0x00C0;
    stress_reg_t REG_049 @ 0x00C4;
    stress_reg_t REG_050 @ 0x00C8;
    stress_reg_t REG_051 @ 0x00CC;
    stress_reg_t REG_052 @ 0x00D0;
    stress_reg_t REG_053 @ 0x00D4;
    stress_reg_t REG_054 @ 0x00D8;
    stress_reg_t REG_055 @ 0x00DC;
    stress_reg_t REG_056 @ 0x00E0;
    stress_reg_t REG_057 @ 0x00E4;
    stress_reg_t REG_058 @ 0x00E8;
    stress_reg_t REG_059 @ 0x00EC;
    stress_reg_t REG_060 @ 0x00F0;
    stress_reg_t REG_061 @ 0x00F4;
    stress_reg_t REG_062 @ 0x00F8;
    stress_reg_t REG_063 @ 0x00FC;
    stress_reg_t REG_064 @ 0x0100;
    stress_reg_t REG_065 @ 0x0104;
    stress_reg_t REG_066 @ 0x0108;
    stress_reg_t REG_067 @ 0x010C;
    stress_reg_t REG_068 @ 0x0110;
    stress_reg_t REG_069 @ 0x0114;
    stress_reg_t REG_070 @ 0x0118;
    stress_reg_t REG_071 @ 0x011C;
    stress_reg_t REG_072 @ 0x0120;
    stress_reg_t REG_073 @ 0x0124;
    stress_reg_t REG_074 @ 0x0128;
    stress_reg_t REG_075 @ 0x012C;
    stress_reg_t REG_076 @ 0x0130;
    stress_reg_t REG_077 @ 0x0134;
    stress_reg_t REG_078 @ 0x0138;
    stress_reg_t REG_079 @ 0x013C;
    stress_reg_t REG_080 @ 0x0140;
    stress_reg_t REG_081 @ 0x0144;
    stress_reg_t REG_082 @ 0x0148;
    stress_reg_t REG_083 @ 0x014C;
    stress_reg_t REG_084 @ 0x0150;
    stress_reg_t REG_085 @ 0x0154;
    stress_reg_t REG_086 @ 0x0158;
    stress_reg_t REG_087 @ 0x015C;
    stress_reg_t REG_088 @ 0x0160;
    stress_reg_t REG_089 @ 0x0164;
    stress_reg_t REG_090 @ 0x0168;
    stress_reg_t REG_091 @ 0x016C;
    stress_reg_t REG_092 @ 0x0170;
    stress_reg_t REG_093 @ 0x0174;
    stress_reg_t REG_094 @ 0x0178;
    stress_reg_t REG_095 @ 0x017C;
    stress_reg_t REG_096 @ 0x0180;
    stress_reg_t REG_097 @ 0x0184;
    stress_reg_t REG_098 @ 0x0188;
    stress_reg_t REG_099 @ 0x018C;
};

regfile bank_02_t {
    name = "Bank 02";
    desc = "Bank 02: 100 registers.";
    stress_reg_t REG_000 @ 0x0000;
    stress_reg_t REG_001 @ 0x0004;
    stress_reg_t REG_002 @ 0x0008;
    stress_reg_t REG_003 @ 0x000C;
    stress_reg_t REG_004 @ 0x0010;
    stress_reg_t REG_005 @ 0x0014;
    stress_reg_t REG_006 @ 0x0018;
    stress_reg_t REG_007 @ 0x001C;
    stress_reg_t REG_008 @ 0x0020;
    stress_reg_t REG_009 @ 0x0024;
    stress_reg_t REG_010 @ 0x0028;
    stress_reg_t REG_011 @ 0x002C;
    stress_reg_t REG_012 @ 0x0030;
    stress_reg_t REG_013 @ 0x0034;
    stress_reg_t REG_014 @ 0x0038;
    stress_reg_t REG_015 @ 0x003C;
    stress_reg_t REG_016 @ 0x0040;
    stress_reg_t REG_017 @ 0x0044;
    stress_reg_t REG_018 @ 0x0048;
    stress_reg_t REG_019 @ 0x004C;
    stress_reg_t REG_020 @ 0x0050;
    stress_reg_t REG_021 @ 0x0054;
    stress_reg_t REG_022 @ 0x0058;
    stress_reg_t REG_023 @ 0x005C;
    stress_reg_t REG_024 @ 0x0060;
    stress_reg_t REG_025 @ 0x0064;
    stress_reg_t REG_026 @ 0x0068;
    stress_reg_t REG_027 @ 0x006C;
    stress_reg_t REG_028 @ 0x0070;
    stress_reg_t REG_029 @ 0x0074;
    stress_reg_t REG_030 @ 0x0078;
    stress_reg_t REG_031 @ 0x007C;
    stress_reg_t REG_032 @ 0x0080;
    stress_reg_t REG_033 @ 0x0084;
    stress_reg_t REG_034 @ 0x0088;
    stress_reg_t REG_035 @ 0x008C;
    stress_reg_t REG_036 @ 0x0090;
    stress_reg_t REG_037 @ 0x0094;
    stress_reg_t REG_038 @ 0x0098;
    stress_reg_t REG_039 @ 0x009C;
    stress_reg_t REG_040 @ 0x00A0;
    stress_reg_t REG_041 @ 0x00A4;
    stress_reg_t REG_042 @ 0x00A8;
    stress_reg_t REG_043 @ 0x00AC;
    stress_reg_t REG_044 @ 0x00B0;
    stress_reg_t REG_045 @ 0x00B4;
    stress_reg_t REG_046 @ 0x00B8;
    stress_reg_t REG_047 @ 0x00BC;
    stress_reg_t REG_048 @ 0x00C0;
    stress_reg_t REG_049 @ 0x00C4;
    stress_reg_t REG_050 @ 0x00C8;
    stress_reg_t REG_051 @ 0x00CC;
    stress_reg_t REG_052 @ 0x00D0;
    stress_reg_t REG_053 @ 0x00D4;
    stress_reg_t REG_054 @ 0x00D8;
    stress_reg_t REG_055 @ 0x00DC;
    stress_reg_t REG_056 @ 0x00E0;
    stress_reg_t REG_057 @ 0x00E4;
    stress_reg_t REG_058 @ 0x00E8;
    stress_reg_t REG_059 @ 0x00EC;
    stress_reg_t REG_060 @ 0x00F0;
    stress_reg_t REG_061 @ 0x00F4;
    stress_reg_t REG_062 @ 0x00F8;
    stress_reg_t REG_063 @ 0x00FC;
    stress_reg_t REG_064 @ 0x0100;
    stress_reg_t REG_065 @ 0x0104;
    stress_reg_t REG_066 @ 0x0108;
    stress_reg_t REG_067 @ 0x010C;
    stress_reg_t REG_068 @ 0x0110;
    stress_reg_t REG_069 @ 0x0114;
    stress_reg_t REG_070 @ 0x0118;
    stress_reg_t REG_071 @ 0x011C;
    stress_reg_t REG_072 @ 0x0120;
    stress_reg_t REG_073 @ 0x0124;
    stress_reg_t REG_074 @ 0x0128;
    stress_reg_t REG_075 @ 0x012C;
    stress_reg_t REG_076 @ 0x0130;
    stress_reg_t REG_077 @ 0x0134;
    stress_reg_t REG_078 @ 0x0138;
    stress_reg_t REG_079 @ 0x013C;
    stress_reg_t REG_080 @ 0x0140;
    stress_reg_t REG_081 @ 0x0144;
    stress_reg_t REG_082 @ 0x0148;
    stress_reg_t REG_083 @ 0x014C;
    stress_reg_t REG_084 @ 0x0150;
    stress_reg_t REG_085 @ 0x0154;
    stress_reg_t REG_086 @ 0x0158;
    stress_reg_t REG_087 @ 0x015C;
    stress_reg_t REG_088 @ 0x0160;
    stress_reg_t REG_089 @ 0x0164;
    stress_reg_t REG_090 @ 0x0168;
    stress_reg_t REG_091 @ 0x016C;
    stress_reg_t REG_092 @ 0x0170;
    stress_reg_t REG_093 @ 0x0174;
    stress_reg_t REG_094 @ 0x0178;
    stress_reg_t REG_095 @ 0x017C;
    stress_reg_t REG_096 @ 0x0180;
    stress_reg_t REG_097 @ 0x0184;
    stress_reg_t REG_098 @ 0x0188;
    stress_reg_t REG_099 @ 0x018C;
};

regfile bank_03_t {
    name = "Bank 03";
    desc = "Bank 03: 100 registers.";
    stress_reg_t REG_000 @ 0x0000;
    stress_reg_t REG_001 @ 0x0004;
    stress_reg_t REG_002 @ 0x0008;
    stress_reg_t REG_003 @ 0x000C;
    stress_reg_t REG_004 @ 0x0010;
    stress_reg_t REG_005 @ 0x0014;
    stress_reg_t REG_006 @ 0x0018;
    stress_reg_t REG_007 @ 0x001C;
    stress_reg_t REG_008 @ 0x0020;
    stress_reg_t REG_009 @ 0x0024;
    stress_reg_t REG_010 @ 0x0028;
    stress_reg_t REG_011 @ 0x002C;
    stress_reg_t REG_012 @ 0x0030;
    stress_reg_t REG_013 @ 0x0034;
    stress_reg_t REG_014 @ 0x0038;
    stress_reg_t REG_015 @ 0x003C;
    stress_reg_t REG_016 @ 0x0040;
    stress_reg_t REG_017 @ 0x0044;
    stress_reg_t REG_018 @ 0x0048;
    stress_reg_t REG_019 @ 0x004C;
    stress_reg_t REG_020 @ 0x0050;
    stress_reg_t REG_021 @ 0x0054;
    stress_reg_t REG_022 @ 0x0058;
    stress_reg_t REG_023 @ 0x005C;
    stress_reg_t REG_024 @ 0x0060;
    stress_reg_t REG_025 @ 0x0064;
    stress_reg_t REG_026 @ 0x0068;
    stress_reg_t REG_027 @ 0x006C;
    stress_reg_t REG_028 @ 0x0070;
    stress_reg_t REG_029 @ 0x0074;
    stress_reg_t REG_030 @ 0x0078;
    stress_reg_t REG_031 @ 0x007C;
    stress_reg_t REG_032 @ 0x0080;
    stress_reg_t REG_033 @ 0x0084;
    stress_reg_t REG_034 @ 0x0088;
    stress_reg_t REG_035 @ 0x008C;
    stress_reg_t REG_036 @ 0x0090;
    stress_reg_t REG_037 @ 0x0094;
    stress_reg_t REG_038 @ 0x0098;
    stress_reg_t REG_039 @ 0x009C;
    stress_reg_t REG_040 @ 0x00A0;
    stress_reg_t REG_041 @ 0x00A4;
    stress_reg_t REG_042 @ 0x00A8;
    stress_reg_t REG_043 @ 0x00AC;
    stress_reg_t REG_044 @ 0x00B0;
    stress_reg_t REG_045 @ 0x00B4;
    stress_reg_t REG_046 @ 0x00B8;
    stress_reg_t REG_047 @ 0x00BC;
    stress_reg_t REG_048 @ 0x00C0;
    stress_reg_t REG_049 @ 0x00C4;
    stress_reg_t REG_050 @ 0x00C8;
    stress_reg_t REG_051 @ 0x00CC;
    stress_reg_t REG_052 @ 0x00D0;
    stress_reg_t REG_053 @ 0x00D4;
    stress_reg_t REG_054 @ 0x00D8;
    stress_reg_t REG_055 @ 0x00DC;
    stress_reg_t REG_056 @ 0x00E0;
    stress_reg_t REG_057 @ 0x00E4;
    stress_reg_t REG_058 @ 0x00E8;
    stress_reg_t REG_059 @ 0x00EC;
    stress_reg_t REG_060 @ 0x00F0;
    stress_reg_t REG_061 @ 0x00F4;
    stress_reg_t REG_062 @ 0x00F8;
    stress_reg_t REG_063 @ 0x00FC;
    stress_reg_t REG_064 @ 0x0100;
    stress_reg_t REG_065 @ 0x0104;
    stress_reg_t REG_066 @ 0x0108;
    stress_reg_t REG_067 @ 0x010C;
    stress_reg_t REG_068 @ 0x0110;
    stress_reg_t REG_069 @ 0x0114;
    stress_reg_t REG_070 @ 0x0118;
    stress_reg_t REG_071 @ 0x011C;
    stress_reg_t REG_072 @ 0x0120;
    stress_reg_t REG_073 @ 0x0124;
    stress_reg_t REG_074 @ 0x0128;
    stress_reg_t REG_075 @ 0x012C;
    stress_reg_t REG_076 @ 0x0130;
    stress_reg_t REG_077 @ 0x0134;
    stress_reg_t REG_078 @ 0x0138;
    stress_reg_t REG_079 @ 0x013C;
    stress_reg_t REG_080 @ 0x0140;
    stress_reg_t REG_081 @ 0x0144;
    stress_reg_t REG_082 @ 0x0148;
    stress_reg_t REG_083 @ 0x014C;
    stress_reg_t REG_084 @ 0x0150;
    stress_reg_t REG_085 @ 0x0154;
    stress_reg_t REG_086 @ 0x0158;
    stress_reg_t REG_087 @ 0x015C;
    stress_reg_t REG_088 @ 0x0160;
    stress_reg_t REG_089 @ 0x0164;
    stress_reg_t REG_090 @ 0x0168;
    stress_reg_t REG_091 @ 0x016C;
    stress_reg_t REG_092 @ 0x0170;
    stress_reg_t REG_093 @ 0x0174;
    stress_reg_t REG_094 @ 0x0178;
    stress_reg_t REG_095 @ 0x017C;
    stress_reg_t REG_096 @ 0x0180;
    stress_reg_t REG_097 @ 0x0184;
    stress_reg_t REG_098 @ 0x0188;
    stress_reg_t REG_099 @ 0x018C;
};

regfile bank_04_t {
    name = "Bank 04";
    desc = "Bank 04: 100 registers.";
    stress_reg_t REG_000 @ 0x0000;
    stress_reg_t REG_001 @ 0x0004;
    stress_reg_t REG_002 @ 0x0008;
    stress_reg_t REG_003 @ 0x000C;
    stress_reg_t REG_004 @ 0x0010;
    stress_reg_t REG_005 @ 0x0014;
    stress_reg_t REG_006 @ 0x0018;
    stress_reg_t REG_007 @ 0x001C;
    stress_reg_t REG_008 @ 0x0020;
    stress_reg_t REG_009 @ 0x0024;
    stress_reg_t REG_010 @ 0x0028;
    stress_reg_t REG_011 @ 0x002C;
    stress_reg_t REG_012 @ 0x0030;
    stress_reg_t REG_013 @ 0x0034;
    stress_reg_t REG_014 @ 0x0038;
    stress_reg_t REG_015 @ 0x003C;
    stress_reg_t REG_016 @ 0x0040;
    stress_reg_t REG_017 @ 0x0044;
    stress_reg_t REG_018 @ 0x0048;
    stress_reg_t REG_019 @ 0x004C;
    stress_reg_t REG_020 @ 0x0050;
    stress_reg_t REG_021 @ 0x0054;
    stress_reg_t REG_022 @ 0x0058;
    stress_reg_t REG_023 @ 0x005C;
    stress_reg_t REG_024 @ 0x0060;
    stress_reg_t REG_025 @ 0x0064;
    stress_reg_t REG_026 @ 0x0068;
    stress_reg_t REG_027 @ 0x006C;
    stress_reg_t REG_028 @ 0x0070;
    stress_reg_t REG_029 @ 0x0074;
    stress_reg_t REG_030 @ 0x0078;
    stress_reg_t REG_031 @ 0x007C;
    stress_reg_t REG_032 @ 0x0080;
    stress_reg_t REG_033 @ 0x0084;
    stress_reg_t REG_034 @ 0x0088;
    stress_reg_t REG_035 @ 0x008C;
    stress_reg_t REG_036 @ 0x0090;
    stress_reg_t REG_037 @ 0x0094;
    stress_reg_t REG_038 @ 0x0098;
    stress_reg_t REG_039 @ 0x009C;
    stress_reg_t REG_040 @ 0x00A0;
    stress_reg_t REG_041 @ 0x00A4;
    stress_reg_t REG_042 @ 0x00A8;
    stress_reg_t REG_043 @ 0x00AC;
    stress_reg_t REG_044 @ 0x00B0;
    stress_reg_t REG_045 @ 0x00B4;
    stress_reg_t REG_046 @ 0x00B8;
    stress_reg_t REG_047 @ 0x00BC;
    stress_reg_t REG_048 @ 0x00C0;
    stress_reg_t REG_049 @ 0x00C4;
    stress_reg_t REG_050 @ 0x00C8;
    stress_reg_t REG_051 @ 0x00CC;
    stress_reg_t REG_052 @ 0x00D0;
    stress_reg_t REG_053 @ 0x00D4;
    stress_reg_t REG_054 @ 0x00D8;
    stress_reg_t REG_055 @ 0x00DC;
    stress_reg_t REG_056 @ 0x00E0;
    stress_reg_t REG_057 @ 0x00E4;
    stress_reg_t REG_058 @ 0x00E8;
    stress_reg_t REG_059 @ 0x00EC;
    stress_reg_t REG_060 @ 0x00F0;
    stress_reg_t REG_061 @ 0x00F4;
    stress_reg_t REG_062 @ 0x00F8;
    stress_reg_t REG_063 @ 0x00FC;
    stress_reg_t REG_064 @ 0x0100;
    stress_reg_t REG_065 @ 0x0104;
    stress_reg_t REG_066 @ 0x0108;
    stress_reg_t REG_067 @ 0x010C;
    stress_reg_t REG_068 @ 0x0110;
    stress_reg_t REG_069 @ 0x0114;
    stress_reg_t REG_070 @ 0x0118;
    stress_reg_t REG_071 @ 0x011C;
    stress_reg_t REG_072 @ 0x0120;
    stress_reg_t REG_073 @ 0x0124;
    stress_reg_t REG_074 @ 0x0128;
    stress_reg_t REG_075 @ 0x012C;
    stress_reg_t REG_076 @ 0x0130;
    stress_reg_t REG_077 @ 0x0134;
    stress_reg_t REG_078 @ 0x0138;
    stress_reg_t REG_079 @ 0x013C;
    stress_reg_t REG_080 @ 0x0140;
    stress_reg_t REG_081 @ 0x0144;
    stress_reg_t REG_082 @ 0x0148;
    stress_reg_t REG_083 @ 0x014C;
    stress_reg_t REG_084 @ 0x0150;
    stress_reg_t REG_085 @ 0x0154;
    stress_reg_t REG_086 @ 0x0158;
    stress_reg_t REG_087 @ 0x015C;
    stress_reg_t REG_088 @ 0x0160;
    stress_reg_t REG_089 @ 0x0164;
    stress_reg_t REG_090 @ 0x0168;
    stress_reg_t REG_091 @ 0x016C;
    stress_reg_t REG_092 @ 0x0170;
    stress_reg_t REG_093 @ 0x0174;
    stress_reg_t REG_094 @ 0x0178;
    stress_reg_t REG_095 @ 0x017C;
    stress_reg_t REG_096 @ 0x0180;
    stress_reg_t REG_097 @ 0x0184;
    stress_reg_t REG_098 @ 0x0188;
    stress_reg_t REG_099 @ 0x018C;
};

regfile bank_05_t {
    name = "Bank 05";
    desc = "Bank 05: 100 registers.";
    stress_reg_t REG_000 @ 0x0000;
    stress_reg_t REG_001 @ 0x0004;
    stress_reg_t REG_002 @ 0x0008;
    stress_reg_t REG_003 @ 0x000C;
    stress_reg_t REG_004 @ 0x0010;
    stress_reg_t REG_005 @ 0x0014;
    stress_reg_t REG_006 @ 0x0018;
    stress_reg_t REG_007 @ 0x001C;
    stress_reg_t REG_008 @ 0x0020;
    stress_reg_t REG_009 @ 0x0024;
    stress_reg_t REG_010 @ 0x0028;
    stress_reg_t REG_011 @ 0x002C;
    stress_reg_t REG_012 @ 0x0030;
    stress_reg_t REG_013 @ 0x0034;
    stress_reg_t REG_014 @ 0x0038;
    stress_reg_t REG_015 @ 0x003C;
    stress_reg_t REG_016 @ 0x0040;
    stress_reg_t REG_017 @ 0x0044;
    stress_reg_t REG_018 @ 0x0048;
    stress_reg_t REG_019 @ 0x004C;
    stress_reg_t REG_020 @ 0x0050;
    stress_reg_t REG_021 @ 0x0054;
    stress_reg_t REG_022 @ 0x0058;
    stress_reg_t REG_023 @ 0x005C;
    stress_reg_t REG_024 @ 0x0060;
    stress_reg_t REG_025 @ 0x0064;
    stress_reg_t REG_026 @ 0x0068;
    stress_reg_t REG_027 @ 0x006C;
    stress_reg_t REG_028 @ 0x0070;
    stress_reg_t REG_029 @ 0x0074;
    stress_reg_t REG_030 @ 0x0078;
    stress_reg_t REG_031 @ 0x007C;
    stress_reg_t REG_032 @ 0x0080;
    stress_reg_t REG_033 @ 0x0084;
    stress_reg_t REG_034 @ 0x0088;
    stress_reg_t REG_035 @ 0x008C;
    stress_reg_t REG_036 @ 0x0090;
    stress_reg_t REG_037 @ 0x0094;
    stress_reg_t REG_038 @ 0x0098;
    stress_reg_t REG_039 @ 0x009C;
    stress_reg_t REG_040 @ 0x00A0;
    stress_reg_t REG_041 @ 0x00A4;
    stress_reg_t REG_042 @ 0x00A8;
    stress_reg_t REG_043 @ 0x00AC;
    stress_reg_t REG_044 @ 0x00B0;
    stress_reg_t REG_045 @ 0x00B4;
    stress_reg_t REG_046 @ 0x00B8;
    stress_reg_t REG_047 @ 0x00BC;
    stress_reg_t REG_048 @ 0x00C0;
    stress_reg_t REG_049 @ 0x00C4;
    stress_reg_t REG_050 @ 0x00C8;
    stress_reg_t REG_051 @ 0x00CC;
    stress_reg_t REG_052 @ 0x00D0;
    stress_reg_t REG_053 @ 0x00D4;
    stress_reg_t REG_054 @ 0x00D8;
    stress_reg_t REG_055 @ 0x00DC;
    stress_reg_t REG_056 @ 0x00E0;
    stress_reg_t REG_057 @ 0x00E4;
    stress_reg_t REG_058 @ 0x00E8;
    stress_reg_t REG_059 @ 0x00EC;
    stress_reg_t REG_060 @ 0x00F0;
    stress_reg_t REG_061 @ 0x00F4;
    stress_reg_t REG_062 @ 0x00F8;
    stress_reg_t REG_063 @ 0x00FC;
    stress_reg_t REG_064 @ 0x0100;
    stress_reg_t REG_065 @ 0x0104;
    stress_reg_t REG_066 @ 0x0108;
    stress_reg_t REG_067 @ 0x010C;
    stress_reg_t REG_068 @ 0x0110;
    stress_reg_t REG_069 @ 0x0114;
    stress_reg_t REG_070 @ 0x0118;
    stress_reg_t REG_071 @ 0x011C;
    stress_reg_t REG_072 @ 0x0120;
    stress_reg_t REG_073 @ 0x0124;
    stress_reg_t REG_074 @ 0x0128;
    stress_reg_t REG_075 @ 0x012C;
    stress_reg_t REG_076 @ 0x0130;
    stress_reg_t REG_077 @ 0x0134;
    stress_reg_t REG_078 @ 0x0138;
    stress_reg_t REG_079 @ 0x013C;
    stress_reg_t REG_080 @ 0x0140;
    stress_reg_t REG_081 @ 0x0144;
    stress_reg_t REG_082 @ 0x0148;
    stress_reg_t REG_083 @ 0x014C;
    stress_reg_t REG_084 @ 0x0150;
    stress_reg_t REG_085 @ 0x0154;
    stress_reg_t REG_086 @ 0x0158;
    stress_reg_t REG_087 @ 0x015C;
    stress_reg_t REG_088 @ 0x0160;
    stress_reg_t REG_089 @ 0x0164;
    stress_reg_t REG_090 @ 0x0168;
    stress_reg_t REG_091 @ 0x016C;
    stress_reg_t REG_092 @ 0x0170;
    stress_reg_t REG_093 @ 0x0174;
    stress_reg_t REG_094 @ 0x0178;
    stress_reg_t REG_095 @ 0x017C;
    stress_reg_t REG_096 @ 0x0180;
    stress_reg_t REG_097 @ 0x0184;
    stress_reg_t REG_098 @ 0x0188;
    stress_reg_t REG_099 @ 0x018C;
};

regfile bank_06_t {
    name = "Bank 06";
    desc = "Bank 06: 100 registers.";
    stress_reg_t REG_000 @ 0x0000;
    stress_reg_t REG_001 @ 0x0004;
    stress_reg_t REG_002 @ 0x0008;
    stress_reg_t REG_003 @ 0x000C;
    stress_reg_t REG_004 @ 0x0010;
    stress_reg_t REG_005 @ 0x0014;
    stress_reg_t REG_006 @ 0x0018;
    stress_reg_t REG_007 @ 0x001C;
    stress_reg_t REG_008 @ 0x0020;
    stress_reg_t REG_009 @ 0x0024;
    stress_reg_t REG_010 @ 0x0028;
    stress_reg_t REG_011 @ 0x002C;
    stress_reg_t REG_012 @ 0x0030;
    stress_reg_t REG_013 @ 0x0034;
    stress_reg_t REG_014 @ 0x0038;
    stress_reg_t REG_015 @ 0x003C;
    stress_reg_t REG_016 @ 0x0040;
    stress_reg_t REG_017 @ 0x0044;
    stress_reg_t REG_018 @ 0x0048;
    stress_reg_t REG_019 @ 0x004C;
    stress_reg_t REG_020 @ 0x0050;
    stress_reg_t REG_021 @ 0x0054;
    stress_reg_t REG_022 @ 0x0058;
    stress_reg_t REG_023 @ 0x005C;
    stress_reg_t REG_024 @ 0x0060;
    stress_reg_t REG_025 @ 0x0064;
    stress_reg_t REG_026 @ 0x0068;
    stress_reg_t REG_027 @ 0x006C;
    stress_reg_t REG_028 @ 0x0070;
    stress_reg_t REG_029 @ 0x0074;
    stress_reg_t REG_030 @ 0x0078;
    stress_reg_t REG_031 @ 0x007C;
    stress_reg_t REG_032 @ 0x0080;
    stress_reg_t REG_033 @ 0x0084;
    stress_reg_t REG_034 @ 0x0088;
    stress_reg_t REG_035 @ 0x008C;
    stress_reg_t REG_036 @ 0x0090;
    stress_reg_t REG_037 @ 0x0094;
    stress_reg_t REG_038 @ 0x0098;
    stress_reg_t REG_039 @ 0x009C;
    stress_reg_t REG_040 @ 0x00A0;
    stress_reg_t REG_041 @ 0x00A4;
    stress_reg_t REG_042 @ 0x00A8;
    stress_reg_t REG_043 @ 0x00AC;
    stress_reg_t REG_044 @ 0x00B0;
    stress_reg_t REG_045 @ 0x00B4;
    stress_reg_t REG_046 @ 0x00B8;
    stress_reg_t REG_047 @ 0x00BC;
    stress_reg_t REG_048 @ 0x00C0;
    stress_reg_t REG_049 @ 0x00C4;
    stress_reg_t REG_050 @ 0x00C8;
    stress_reg_t REG_051 @ 0x00CC;
    stress_reg_t REG_052 @ 0x00D0;
    stress_reg_t REG_053 @ 0x00D4;
    stress_reg_t REG_054 @ 0x00D8;
    stress_reg_t REG_055 @ 0x00DC;
    stress_reg_t REG_056 @ 0x00E0;
    stress_reg_t REG_057 @ 0x00E4;
    stress_reg_t REG_058 @ 0x00E8;
    stress_reg_t REG_059 @ 0x00EC;
    stress_reg_t REG_060 @ 0x00F0;
    stress_reg_t REG_061 @ 0x00F4;
    stress_reg_t REG_062 @ 0x00F8;
    stress_reg_t REG_063 @ 0x00FC;
    stress_reg_t REG_064 @ 0x0100;
    stress_reg_t REG_065 @ 0x0104;
    stress_reg_t REG_066 @ 0x0108;
    stress_reg_t REG_067 @ 0x010C;
    stress_reg_t REG_068 @ 0x0110;
    stress_reg_t REG_069 @ 0x0114;
    stress_reg_t REG_070 @ 0x0118;
    stress_reg_t REG_071 @ 0x011C;
    stress_reg_t REG_072 @ 0x0120;
    stress_reg_t REG_073 @ 0x0124;
    stress_reg_t REG_074 @ 0x0128;
    stress_reg_t REG_075 @ 0x012C;
    stress_reg_t REG_076 @ 0x0130;
    stress_reg_t REG_077 @ 0x0134;
    stress_reg_t REG_078 @ 0x0138;
    stress_reg_t REG_079 @ 0x013C;
    stress_reg_t REG_080 @ 0x0140;
    stress_reg_t REG_081 @ 0x0144;
    stress_reg_t REG_082 @ 0x0148;
    stress_reg_t REG_083 @ 0x014C;
    stress_reg_t REG_084 @ 0x0150;
    stress_reg_t REG_085 @ 0x0154;
    stress_reg_t REG_086 @ 0x0158;
    stress_reg_t REG_087 @ 0x015C;
    stress_reg_t REG_088 @ 0x0160;
    stress_reg_t REG_089 @ 0x0164;
    stress_reg_t REG_090 @ 0x0168;
    stress_reg_t REG_091 @ 0x016C;
    stress_reg_t REG_092 @ 0x0170;
    stress_reg_t REG_093 @ 0x0174;
    stress_reg_t REG_094 @ 0x0178;
    stress_reg_t REG_095 @ 0x017C;
    stress_reg_t REG_096 @ 0x0180;
    stress_reg_t REG_097 @ 0x0184;
    stress_reg_t REG_098 @ 0x0188;
    stress_reg_t REG_099 @ 0x018C;
};

regfile bank_07_t {
    name = "Bank 07";
    desc = "Bank 07: 100 registers.";
    stress_reg_t REG_000 @ 0x0000;
    stress_reg_t REG_001 @ 0x0004;
    stress_reg_t REG_002 @ 0x0008;
    stress_reg_t REG_003 @ 0x000C;
    stress_reg_t REG_004 @ 0x0010;
    stress_reg_t REG_005 @ 0x0014;
    stress_reg_t REG_006 @ 0x0018;
    stress_reg_t REG_007 @ 0x001C;
    stress_reg_t REG_008 @ 0x0020;
    stress_reg_t REG_009 @ 0x0024;
    stress_reg_t REG_010 @ 0x0028;
    stress_reg_t REG_011 @ 0x002C;
    stress_reg_t REG_012 @ 0x0030;
    stress_reg_t REG_013 @ 0x0034;
    stress_reg_t REG_014 @ 0x0038;
    stress_reg_t REG_015 @ 0x003C;
    stress_reg_t REG_016 @ 0x0040;
    stress_reg_t REG_017 @ 0x0044;
    stress_reg_t REG_018 @ 0x0048;
    stress_reg_t REG_019 @ 0x004C;
    stress_reg_t REG_020 @ 0x0050;
    stress_reg_t REG_021 @ 0x0054;
    stress_reg_t REG_022 @ 0x0058;
    stress_reg_t REG_023 @ 0x005C;
    stress_reg_t REG_024 @ 0x0060;
    stress_reg_t REG_025 @ 0x0064;
    stress_reg_t REG_026 @ 0x0068;
    stress_reg_t REG_027 @ 0x006C;
    stress_reg_t REG_028 @ 0x0070;
    stress_reg_t REG_029 @ 0x0074;
    stress_reg_t REG_030 @ 0x0078;
    stress_reg_t REG_031 @ 0x007C;
    stress_reg_t REG_032 @ 0x0080;
    stress_reg_t REG_033 @ 0x0084;
    stress_reg_t REG_034 @ 0x0088;
    stress_reg_t REG_035 @ 0x008C;
    stress_reg_t REG_036 @ 0x0090;
    stress_reg_t REG_037 @ 0x0094;
    stress_reg_t REG_038 @ 0x0098;
    stress_reg_t REG_039 @ 0x009C;
    stress_reg_t REG_040 @ 0x00A0;
    stress_reg_t REG_041 @ 0x00A4;
    stress_reg_t REG_042 @ 0x00A8;
    stress_reg_t REG_043 @ 0x00AC;
    stress_reg_t REG_044 @ 0x00B0;
    stress_reg_t REG_045 @ 0x00B4;
    stress_reg_t REG_046 @ 0x00B8;
    stress_reg_t REG_047 @ 0x00BC;
    stress_reg_t REG_048 @ 0x00C0;
    stress_reg_t REG_049 @ 0x00C4;
    stress_reg_t REG_050 @ 0x00C8;
    stress_reg_t REG_051 @ 0x00CC;
    stress_reg_t REG_052 @ 0x00D0;
    stress_reg_t REG_053 @ 0x00D4;
    stress_reg_t REG_054 @ 0x00D8;
    stress_reg_t REG_055 @ 0x00DC;
    stress_reg_t REG_056 @ 0x00E0;
    stress_reg_t REG_057 @ 0x00E4;
    stress_reg_t REG_058 @ 0x00E8;
    stress_reg_t REG_059 @ 0x00EC;
    stress_reg_t REG_060 @ 0x00F0;
    stress_reg_t REG_061 @ 0x00F4;
    stress_reg_t REG_062 @ 0x00F8;
    stress_reg_t REG_063 @ 0x00FC;
    stress_reg_t REG_064 @ 0x0100;
    stress_reg_t REG_065 @ 0x0104;
    stress_reg_t REG_066 @ 0x0108;
    stress_reg_t REG_067 @ 0x010C;
    stress_reg_t REG_068 @ 0x0110;
    stress_reg_t REG_069 @ 0x0114;
    stress_reg_t REG_070 @ 0x0118;
    stress_reg_t REG_071 @ 0x011C;
    stress_reg_t REG_072 @ 0x0120;
    stress_reg_t REG_073 @ 0x0124;
    stress_reg_t REG_074 @ 0x0128;
    stress_reg_t REG_075 @ 0x012C;
    stress_reg_t REG_076 @ 0x0130;
    stress_reg_t REG_077 @ 0x0134;
    stress_reg_t REG_078 @ 0x0138;
    stress_reg_t REG_079 @ 0x013C;
    stress_reg_t REG_080 @ 0x0140;
    stress_reg_t REG_081 @ 0x0144;
    stress_reg_t REG_082 @ 0x0148;
    stress_reg_t REG_083 @ 0x014C;
    stress_reg_t REG_084 @ 0x0150;
    stress_reg_t REG_085 @ 0x0154;
    stress_reg_t REG_086 @ 0x0158;
    stress_reg_t REG_087 @ 0x015C;
    stress_reg_t REG_088 @ 0x0160;
    stress_reg_t REG_089 @ 0x0164;
    stress_reg_t REG_090 @ 0x0168;
    stress_reg_t REG_091 @ 0x016C;
    stress_reg_t REG_092 @ 0x0170;
    stress_reg_t REG_093 @ 0x0174;
    stress_reg_t REG_094 @ 0x0178;
    stress_reg_t REG_095 @ 0x017C;
    stress_reg_t REG_096 @ 0x0180;
    stress_reg_t REG_097 @ 0x0184;
    stress_reg_t REG_098 @ 0x0188;
    stress_reg_t REG_099 @ 0x018C;
};

regfile bank_08_t {
    name = "Bank 08";
    desc = "Bank 08: 100 registers.";
    stress_reg_t REG_000 @ 0x0000;
    stress_reg_t REG_001 @ 0x0004;
    stress_reg_t REG_002 @ 0x0008;
    stress_reg_t REG_003 @ 0x000C;
    stress_reg_t REG_004 @ 0x0010;
    stress_reg_t REG_005 @ 0x0014;
    stress_reg_t REG_006 @ 0x0018;
    stress_reg_t REG_007 @ 0x001C;
    stress_reg_t REG_008 @ 0x0020;
    stress_reg_t REG_009 @ 0x0024;
    stress_reg_t REG_010 @ 0x0028;
    stress_reg_t REG_011 @ 0x002C;
    stress_reg_t REG_012 @ 0x0030;
    stress_reg_t REG_013 @ 0x0034;
    stress_reg_t REG_014 @ 0x0038;
    stress_reg_t REG_015 @ 0x003C;
    stress_reg_t REG_016 @ 0x0040;
    stress_reg_t REG_017 @ 0x0044;
    stress_reg_t REG_018 @ 0x0048;
    stress_reg_t REG_019 @ 0x004C;
    stress_reg_t REG_020 @ 0x0050;
    stress_reg_t REG_021 @ 0x0054;
    stress_reg_t REG_022 @ 0x0058;
    stress_reg_t REG_023 @ 0x005C;
    stress_reg_t REG_024 @ 0x0060;
    stress_reg_t REG_025 @ 0x0064;
    stress_reg_t REG_026 @ 0x0068;
    stress_reg_t REG_027 @ 0x006C;
    stress_reg_t REG_028 @ 0x0070;
    stress_reg_t REG_029 @ 0x0074;
    stress_reg_t REG_030 @ 0x0078;
    stress_reg_t REG_031 @ 0x007C;
    stress_reg_t REG_032 @ 0x0080;
    stress_reg_t REG_033 @ 0x0084;
    stress_reg_t REG_034 @ 0x0088;
    stress_reg_t REG_035 @ 0x008C;
    stress_reg_t REG_036 @ 0x0090;
    stress_reg_t REG_037 @ 0x0094;
    stress_reg_t REG_038 @ 0x0098;
    stress_reg_t REG_039 @ 0x009C;
    stress_reg_t REG_040 @ 0x00A0;
    stress_reg_t REG_041 @ 0x00A4;
    stress_reg_t REG_042 @ 0x00A8;
    stress_reg_t REG_043 @ 0x00AC;
    stress_reg_t REG_044 @ 0x00B0;
    stress_reg_t REG_045 @ 0x00B4;
    stress_reg_t REG_046 @ 0x00B8;
    stress_reg_t REG_047 @ 0x00BC;
    stress_reg_t REG_048 @ 0x00C0;
    stress_reg_t REG_049 @ 0x00C4;
    stress_reg_t REG_050 @ 0x00C8;
    stress_reg_t REG_051 @ 0x00CC;
    stress_reg_t REG_052 @ 0x00D0;
    stress_reg_t REG_053 @ 0x00D4;
    stress_reg_t REG_054 @ 0x00D8;
    stress_reg_t REG_055 @ 0x00DC;
    stress_reg_t REG_056 @ 0x00E0;
    stress_reg_t REG_057 @ 0x00E4;
    stress_reg_t REG_058 @ 0x00E8;
    stress_reg_t REG_059 @ 0x00EC;
    stress_reg_t REG_060 @ 0x00F0;
    stress_reg_t REG_061 @ 0x00F4;
    stress_reg_t REG_062 @ 0x00F8;
    stress_reg_t REG_063 @ 0x00FC;
    stress_reg_t REG_064 @ 0x0100;
    stress_reg_t REG_065 @ 0x0104;
    stress_reg_t REG_066 @ 0x0108;
    stress_reg_t REG_067 @ 0x010C;
    stress_reg_t REG_068 @ 0x0110;
    stress_reg_t REG_069 @ 0x0114;
    stress_reg_t REG_070 @ 0x0118;
    stress_reg_t REG_071 @ 0x011C;
    stress_reg_t REG_072 @ 0x0120;
    stress_reg_t REG_073 @ 0x0124;
    stress_reg_t REG_074 @ 0x0128;
    stress_reg_t REG_075 @ 0x012C;
    stress_reg_t REG_076 @ 0x0130;
    stress_reg_t REG_077 @ 0x0134;
    stress_reg_t REG_078 @ 0x0138;
    stress_reg_t REG_079 @ 0x013C;
    stress_reg_t REG_080 @ 0x0140;
    stress_reg_t REG_081 @ 0x0144;
    stress_reg_t REG_082 @ 0x0148;
    stress_reg_t REG_083 @ 0x014C;
    stress_reg_t REG_084 @ 0x0150;
    stress_reg_t REG_085 @ 0x0154;
    stress_reg_t REG_086 @ 0x0158;
    stress_reg_t REG_087 @ 0x015C;
    stress_reg_t REG_088 @ 0x0160;
    stress_reg_t REG_089 @ 0x0164;
    stress_reg_t REG_090 @ 0x0168;
    stress_reg_t REG_091 @ 0x016C;
    stress_reg_t REG_092 @ 0x0170;
    stress_reg_t REG_093 @ 0x0174;
    stress_reg_t REG_094 @ 0x0178;
    stress_reg_t REG_095 @ 0x017C;
    stress_reg_t REG_096 @ 0x0180;
    stress_reg_t REG_097 @ 0x0184;
    stress_reg_t REG_098 @ 0x0188;
    stress_reg_t REG_099 @ 0x018C;
};

regfile bank_09_t {
    name = "Bank 09";
    desc = "Bank 09: 100 registers.";
    stress_reg_t REG_000 @ 0x0000;
    stress_reg_t REG_001 @ 0x0004;
    stress_reg_t REG_002 @ 0x0008;
    stress_reg_t REG_003 @ 0x000C;
    stress_reg_t REG_004 @ 0x0010;
    stress_reg_t REG_005 @ 0x0014;
    stress_reg_t REG_006 @ 0x0018;
    stress_reg_t REG_007 @ 0x001C;
    stress_reg_t REG_008 @ 0x0020;
    stress_reg_t REG_009 @ 0x0024;
    stress_reg_t REG_010 @ 0x0028;
    stress_reg_t REG_011 @ 0x002C;
    stress_reg_t REG_012 @ 0x0030;
    stress_reg_t REG_013 @ 0x0034;
    stress_reg_t REG_014 @ 0x0038;
    stress_reg_t REG_015 @ 0x003C;
    stress_reg_t REG_016 @ 0x0040;
    stress_reg_t REG_017 @ 0x0044;
    stress_reg_t REG_018 @ 0x0048;
    stress_reg_t REG_019 @ 0x004C;
    stress_reg_t REG_020 @ 0x0050;
    stress_reg_t REG_021 @ 0x0054;
    stress_reg_t REG_022 @ 0x0058;
    stress_reg_t REG_023 @ 0x005C;
    stress_reg_t REG_024 @ 0x0060;
    stress_reg_t REG_025 @ 0x0064;
    stress_reg_t REG_026 @ 0x0068;
    stress_reg_t REG_027 @ 0x006C;
    stress_reg_t REG_028 @ 0x0070;
    stress_reg_t REG_029 @ 0x0074;
    stress_reg_t REG_030 @ 0x0078;
    stress_reg_t REG_031 @ 0x007C;
    stress_reg_t REG_032 @ 0x0080;
    stress_reg_t REG_033 @ 0x0084;
    stress_reg_t REG_034 @ 0x0088;
    stress_reg_t REG_035 @ 0x008C;
    stress_reg_t REG_036 @ 0x0090;
    stress_reg_t REG_037 @ 0x0094;
    stress_reg_t REG_038 @ 0x0098;
    stress_reg_t REG_039 @ 0x009C;
    stress_reg_t REG_040 @ 0x00A0;
    stress_reg_t REG_041 @ 0x00A4;
    stress_reg_t REG_042 @ 0x00A8;
    stress_reg_t REG_043 @ 0x00AC;
    stress_reg_t REG_044 @ 0x00B0;
    stress_reg_t REG_045 @ 0x00B4;
    stress_reg_t REG_046 @ 0x00B8;
    stress_reg_t REG_047 @ 0x00BC;
    stress_reg_t REG_048 @ 0x00C0;
    stress_reg_t REG_049 @ 0x00C4;
    stress_reg_t REG_050 @ 0x00C8;
    stress_reg_t REG_051 @ 0x00CC;
    stress_reg_t REG_052 @ 0x00D0;
    stress_reg_t REG_053 @ 0x00D4;
    stress_reg_t REG_054 @ 0x00D8;
    stress_reg_t REG_055 @ 0x00DC;
    stress_reg_t REG_056 @ 0x00E0;
    stress_reg_t REG_057 @ 0x00E4;
    stress_reg_t REG_058 @ 0x00E8;
    stress_reg_t REG_059 @ 0x00EC;
    stress_reg_t REG_060 @ 0x00F0;
    stress_reg_t REG_061 @ 0x00F4;
    stress_reg_t REG_062 @ 0x00F8;
    stress_reg_t REG_063 @ 0x00FC;
    stress_reg_t REG_064 @ 0x0100;
    stress_reg_t REG_065 @ 0x0104;
    stress_reg_t REG_066 @ 0x0108;
    stress_reg_t REG_067 @ 0x010C;
    stress_reg_t REG_068 @ 0x0110;
    stress_reg_t REG_069 @ 0x0114;
    stress_reg_t REG_070 @ 0x0118;
    stress_reg_t REG_071 @ 0x011C;
    stress_reg_t REG_072 @ 0x0120;
    stress_reg_t REG_073 @ 0x0124;
    stress_reg_t REG_074 @ 0x0128;
    stress_reg_t REG_075 @ 0x012C;
    stress_reg_t REG_076 @ 0x0130;
    stress_reg_t REG_077 @ 0x0134;
    stress_reg_t REG_078 @ 0x0138;
    stress_reg_t REG_079 @ 0x013C;
    stress_reg_t REG_080 @ 0x0140;
    stress_reg_t REG_081 @ 0x0144;
    stress_reg_t REG_082 @ 0x0148;
    stress_reg_t REG_083 @ 0x014C;
    stress_reg_t REG_084 @ 0x0150;
    stress_reg_t REG_085 @ 0x0154;
    stress_reg_t REG_086 @ 0x0158;
    stress_reg_t REG_087 @ 0x015C;
    stress_reg_t REG_088 @ 0x0160;
    stress_reg_t REG_089 @ 0x0164;
    stress_reg_t REG_090 @ 0x0168;
    stress_reg_t REG_091 @ 0x016C;
    stress_reg_t REG_092 @ 0x0170;
    stress_reg_t REG_093 @ 0x0174;
    stress_reg_t REG_094 @ 0x0178;
    stress_reg_t REG_095 @ 0x017C;
    stress_reg_t REG_096 @ 0x0180;
    stress_reg_t REG_097 @ 0x0184;
    stress_reg_t REG_098 @ 0x0188;
    stress_reg_t REG_099 @ 0x018C;
};

addrmap stress_top {
    name = "Stress: 1000 registers × 30 fields";
    desc = "Generated stress fixture for the SystemRDL viewer.";
    bank_00_t bank_00 @ 0x0000;
    bank_01_t bank_01 @ 0x0400;
    bank_02_t bank_02 @ 0x0800;
    bank_03_t bank_03 @ 0x0C00;
    bank_04_t bank_04 @ 0x1000;
    bank_05_t bank_05 @ 0x1400;
    bank_06_t bank_06 @ 0x1800;
    bank_07_t bank_07 @ 0x1C00;
    bank_08_t bank_08 @ 0x2000;
    bank_09_t bank_09 @ 0x2400;
};
